* switch_pin_identifier — Pico internal pull-ups vs an unmarked switch's terminals
*
* Not a powered circuit of its own — the Pico gets its power from the PC's
* USB port and just senses, same as fuse_test_voltmeter. One switch
* terminal is wired directly to the Pico's GND pin (node 0 here); the
* remaining terminal(s) are wired to probe pins, each pulled up
* internally (RP2040 datasheet: nominal ~50 kOhm) to 3.3V. A probe pin
* reads LOW only in whichever switch position mechanically connects its
* terminal to the grounded terminal; it reads HIGH (pulled up) otherwise.
*
* This model: pin A is never connected to the grounded terminal by this
* switch (floats high in both positions shown). Pin B is the active pin —
* it connects to the grounded terminal (through the switch's closed
* contact resistance, a few ohms, modeled as 1 ohm) in position 1, and
* floats in position 2.

Vdd     99 0  DC 3.3

* --- Pin that never connects to the grounded terminal on this switch ---
RpuA    99 A   50k

* --- Active pin, position 1 (switch closed to the grounded terminal) ---
RpuB1   99 B1  50k
RclosedB1 B1 0 1

* --- Active pin, position 2 (switch open / floating) ---
RpuB2   99 B2  50k

.control
op
echo --- Pin A: floating (pulled high) in this switch's positions ---
print v(A)
echo --- Pin B (active pin): position 1 (closed to grounded terminal) vs position 2 (floating) ---
print v(B1) v(B2)
quit
.endc

.end
